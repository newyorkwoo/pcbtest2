SOS key hardware long-press qualifier (SW7, R28, R29, C16, R30, C17, D5 -> 74AUP1G17)
* @title SOS long-press: SOS_TMR must cross the Schmitt VT+ only after ~3 s held
* @plot v(sos_raw) v(sos_tmr) v(sos_press)
* Hand calc: tau = R30*C17 = 910k*4.7u = 4.28 s.  t = tau*ln(3.3/(3.3-VT+))
*   VT+ 1.65 V (nominal, 0.5*VCC) -> 2.96 s ; VT+ 1.3 V (low corner) -> 2.14 s ; VT+ 2.0 V (high corner) -> 3.98 s
* Release: D5 dumps SOS_TMR into R28 (10k) until D5 stops conducting (~0.4 V); the rest leaks via R30+R28.
* A 1 s accidental press starting from that residue must stay below the VT+ low corner (1.3 V).
* @expect t_trip 2.7 3.3
* @expect t_trip_lo 1.9 3.0
* @expect t_trip_hi 3.4 4.3
* @expect v_res 0 0.6
* @expect v_short_max 0 1.25
* @expect v_press_on 3.0 3.35
V33 v33 0 3.3
* SW7 between +3V3 and SOS_RAW: long press 0.5..5.0 s, accidental short press 7.0..8.0 s
VCTL ctl 0 PWL(0 0 0.5 0 0.501 1 5.0 1 5.001 0 7.0 0 7.001 1 8.0 1 8.001 0)
S7 v33 sos_raw ctl 0 SWK
.model SWK SW(Ron=0.1 Roff=1e10 Vt=0.5 Vh=0.1)
R28 sos_raw 0 10k
R29 sos_raw sos_press 1k
C16 sos_press 0 10n
R30 sos_raw sos_tmr 910k
C17 sos_tmr 0 4.7u
D5 sos_tmr sos_raw D1N4148
.model D1N4148 D(Is=2.52n N=1.752 Rs=0.568 Cjo=4p Ikf=0.3)
* 74AUP1G17 input: CMOS, ~1 pF, leakage neglected (<=0.5 uA -> <=0.45 V offset worst case on 910k; see review)
CIN sos_tmr 0 1p
.tran 1m 10
.meas tran t_trip    TRIG v(sos_raw) VAL=1.65 RISE=1 TARG v(sos_tmr) VAL=1.65 RISE=1
.meas tran t_trip_lo TRIG v(sos_raw) VAL=1.65 RISE=1 TARG v(sos_tmr) VAL=1.3 RISE=1
.meas tran t_trip_hi TRIG v(sos_raw) VAL=1.65 RISE=1 TARG v(sos_tmr) VAL=2.0 RISE=1
.meas tran v_res FIND v(sos_tmr) AT=6.0
.meas tran v_short_max MAX v(sos_tmr) FROM=7.0 TO=8.2
.meas tran v_press_on FIND v(sos_press) AT=1.0
.end
